* RC low-pass small-signal sweep
V1 1 0 DC 0 AC 1
R1 1 2 1k
C1 2 0 1u
.ac dec 3 10 1000
