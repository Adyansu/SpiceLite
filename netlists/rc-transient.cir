* Backward-Euler RC charge
V1 1 0 5
R1 1 2 1k
C1 2 0 1u
.tran 1m 5m
